* rlc_bandpass
V1 vin 0 AC 1
R1 vin n1 50
L1 n1 n2 10m
C1 n2 0 100n
R2 n2 0 1k

.control
ac dec 40 10 100k
.endc
.end
