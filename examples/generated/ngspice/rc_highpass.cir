* rc_highpass
V1 vin 0 AC 1
C1 vin vmid 10n
R1 vmid 0 10k

.control
ac dec 20 10 1e6
.endc
.end
